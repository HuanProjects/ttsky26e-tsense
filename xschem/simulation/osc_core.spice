** sch_path: /foss/designs/tt_tsense/xschem/osc_core.sch
**.subckt osc_core vref veb3 thr_sel thr_selb osc_en osc_enb ib_cmp1 ib_cmp2 vcap cmp_raw rst VDPWR VGND
*.ipin vref
*.ipin veb3
*.ipin thr_sel
*.ipin thr_selb
*.iopin ib_cmp1
*.iopin ib_cmp2
*.opin cmp_raw
*.ipin osc_en
*.ipin osc_enb
*.iopin vcap
*.opin rst
*.iopin VDPWR
*.iopin VGND
xmux vref veb3 thr_sel thr_selb vthr VDPWR VGND thrmux
xcmp vthr vcap ib_cmp1 ib_cmp2 VDPWR cmp_raw VGND cmp2s
xos cmp_raw osc_en osc_enb vcap rst VDPWR VGND oneshot
XCosc vcap VGND sky130_fd_pr__cap_mim_m3_1 W=25 L=25 MF=4 m=4
**.ends

* expanding   symbol:  thrmux.sym # of pins=7
** sym_path: /foss/designs/tt_tsense/xschem/thrmux.sym
** sch_path: /foss/designs/tt_tsense/xschem/thrmux.sch
.subckt thrmux vref veb3 thr_sel thr_selb vthr VDPWR VGND
*.ipin thr_sel
*.ipin thr_selb
*.ipin vref
*.ipin veb3
*.iopin vthr
*.iopin VDPWR
*.iopin VGND
xn1 thr_sel seb VGND VGND VDPWR VDPWR sref sky130_fd_sc_hd__nor2_1
xn2 sref thr_selb VGND VGND VDPWR VDPWR seb sky130_fd_sc_hd__nor2_1
xi1 sref VGND VGND VDPWR VDPWR srefb sky130_fd_sc_hd__inv_1
xi2 seb VGND VGND VDPWR VDPWR sebb sky130_fd_sc_hd__inv_1
XMTN1 vref sref vthr VGND sky130_fd_pr__nfet_01v8_lvt L=0.5 W=2 nf=1 ad=0.58 as=0.58 pd=4.58 ps=4.58 nrd=0.145 nrs=0.145 sa=0 sb=0
+ sd=0 mult=1
XMTP1 vthr srefb vref VDPWR sky130_fd_pr__pfet_01v8_lvt L=0.5 W=4 nf=1 ad=1.16 as=1.16 pd=8.58 ps=8.58 nrd=0.0725 nrs=0.0725 sa=0
+ sb=0 sd=0 mult=1
XMTN2 vthr seb veb3 VGND sky130_fd_pr__nfet_01v8_lvt L=0.5 W=2 nf=1 ad=0.58 as=0.58 pd=4.58 ps=4.58 nrd=0.145 nrs=0.145 sa=0 sb=0
+ sd=0 mult=1
XMTP2 veb3 sebb vthr VDPWR sky130_fd_pr__pfet_01v8_lvt L=0.5 W=4 nf=1 ad=1.16 as=1.16 pd=8.58 ps=8.58 nrd=0.0725 nrs=0.0725 sa=0
+ sb=0 sd=0 mult=1
.ends

* expanding   symbol:  cmp2s.sym # of pins=7
** sym_path: /foss/designs/tt_tsense/xschem/cmp2s.sym
** sch_path: /foss/designs/tt_tsense/xschem/cmp2s.sch
.subckt cmp2s vthr vcap ib_cmp1 ib_cmp2 VDPWR cmp_raw VGND
*.iopin VDPWR
*.iopin VGND
*.ipin vthr
*.ipin vcap
*.iopin ib_cmp1
*.iopin ib_cmp2
*.opin cmp_raw
XM2a nd nd VDPWR VDPWR sky130_fd_pr__pfet_01v8_lvt L=4 W=4 nf=1 ad=1.16 as=1.16 pd=8.58 ps=8.58 nrd=0.0725 nrs=0.0725 sa=0 sb=0
+ sd=0 mult=8 m=8
XM2b n1 nd VDPWR VDPWR sky130_fd_pr__pfet_01v8_lvt L=4 W=4 nf=1 ad=1.16 as=1.16 pd=8.58 ps=8.58 nrd=0.0725 nrs=0.0725 sa=0 sb=0
+ sd=0 mult=8 m=8
XM1a nd vthr ib_cmp1 VGND sky130_fd_pr__nfet_01v8_lvt L=1.75 W=10 nf=1 ad=2.9 as=2.9 pd=20.58 ps=20.58 nrd=0.029 nrs=0.029 sa=0
+ sb=0 sd=0 mult=6 m=6
XM1b n1 vcap ib_cmp1 VGND sky130_fd_pr__nfet_01v8_lvt L=1.75 W=10 nf=1 ad=2.9 as=2.9 pd=20.58 ps=20.58 nrd=0.029 nrs=0.029 sa=0
+ sb=0 sd=0 mult=6 m=6
XM3 ib_cmp2 n1 VDPWR VDPWR sky130_fd_pr__pfet_01v8_lvt L=1 W=4 nf=1 ad=1.16 as=1.16 pd=8.58 ps=8.58 nrd=0.0725 nrs=0.0725 sa=0
+ sb=0 sd=0 mult=3 m=3
XMIP x ib_cmp2 VDPWR VDPWR sky130_fd_pr__pfet_01v8 L=1 W=0.42 nf=1 ad=0.1218 as=0.1218 pd=1.42 ps=1.42 nrd=0.69047619047619
+ nrs=0.69047619047619 sa=0 sb=0 sd=0 mult=1
XMIN x ib_cmp2 VGND VGND sky130_fd_pr__nfet_01v8 L=0.15 W=2 nf=1 ad=0.58 as=0.58 pd=4.58 ps=4.58 nrd=0.145 nrs=0.145 sa=0 sb=0
+ sd=0 mult=1
xinv x VGND VGND VDPWR VDPWR cmp_raw sky130_fd_sc_hd__inv_1
.ends

* expanding   symbol:  oneshot.sym # of pins=7
** sym_path: /foss/designs/tt_tsense/xschem/oneshot.sym
** sch_path: /foss/designs/tt_tsense/xschem/oneshot.sch
.subckt oneshot cmp_raw osc_en osc_enb vcap rst VDPWR VGND
*.ipin cmp_raw
*.ipin osc_enb
*.ipin osc_en
*.iopin vcap
*.opin rst
*.iopin VDPWR
*.iopin VGND
xbck cmp_raw VGND VGND VDPWR VDPWR ck sky130_fd_sc_hd__buf_2
xff ck VDPWR rb VGND VGND VDPWR VDPWR rst sky130_fd_sc_hd__dfrtp_1
xor rst osc_enb VGND VGND VDPWR VDPWR swp sky130_fd_sc_hd__or2_1
xi1 swp VGND VGND VDPWR VDPWR swn sky130_fd_sc_hd__inv_1
xand db osc_en VGND VGND VDPWR VDPWR rb sky130_fd_sc_hd__and2_1
xdl rst db VDPWR VGND dly5
XMDP sw swn VDPWR VDPWR sky130_fd_pr__pfet_01v8 L=0.15 W=2 nf=1 ad=0.58 as=0.58 pd=4.58 ps=4.58 nrd=0.145 nrs=0.145 sa=0 sb=0 sd=0
+ mult=1
XMDN sw swn VGND VGND sky130_fd_pr__nfet_01v8 L=1.5 W=0.42 nf=1 ad=0.1218 as=0.1218 pd=1.42 ps=1.42 nrd=0.69047619047619
+ nrs=0.69047619047619 sa=0 sb=0 sd=0 mult=1
XMRST vcap sw VGND VGND sky130_fd_pr__nfet_01v8 L=0.5 W=6 nf=1 ad=1.74 as=1.74 pd=12.58 ps=12.58 nrd=0.0483333333333333
+ nrs=0.0483333333333333 sa=0 sb=0 sd=0 mult=2 m=2
.ends

* expanding   symbol:  dly5.sym # of pins=4
** sym_path: /foss/designs/tt_tsense/xschem/dly5.sym
** sch_path: /foss/designs/tt_tsense/xschem/dly5.sch
.subckt dly5 a y VDPWR VGND
*.iopin VDPWR
*.iopin VGND
*.ipin a
*.opin y
XMP1 d1 a VDPWR VDPWR sky130_fd_pr__pfet_01v8 L=2.3 W=1 nf=1 ad=0.29 as=0.29 pd=2.58 ps=2.58 nrd=0.29 nrs=0.29 sa=0 sb=0 sd=0
+ mult=1
XMN1 d1 a VGND VGND sky130_fd_pr__nfet_01v8 L=2.3 W=0.42 nf=1 ad=0.1218 as=0.1218 pd=1.42 ps=1.42 nrd=0.69047619047619
+ nrs=0.69047619047619 sa=0 sb=0 sd=0 mult=1
XMP2 d2 d1 VDPWR VDPWR sky130_fd_pr__pfet_01v8 L=2.3 W=1 nf=1 ad=0.29 as=0.29 pd=2.58 ps=2.58 nrd=0.29 nrs=0.29 sa=0 sb=0 sd=0
+ mult=1
XMN2 d2 d1 VGND VGND sky130_fd_pr__nfet_01v8 L=2.3 W=0.42 nf=1 ad=0.1218 as=0.1218 pd=1.42 ps=1.42 nrd=0.69047619047619
+ nrs=0.69047619047619 sa=0 sb=0 sd=0 mult=1
XMP3 d3 d2 VDPWR VDPWR sky130_fd_pr__pfet_01v8 L=2.3 W=1 nf=1 ad=0.29 as=0.29 pd=2.58 ps=2.58 nrd=0.29 nrs=0.29 sa=0 sb=0 sd=0
+ mult=1
XMN3 d3 d2 VGND VGND sky130_fd_pr__nfet_01v8 L=2.3 W=0.42 nf=1 ad=0.1218 as=0.1218 pd=1.42 ps=1.42 nrd=0.69047619047619
+ nrs=0.69047619047619 sa=0 sb=0 sd=0 mult=1
XMP4 d4 d3 VDPWR VDPWR sky130_fd_pr__pfet_01v8 L=2.3 W=1 nf=1 ad=0.29 as=0.29 pd=2.58 ps=2.58 nrd=0.29 nrs=0.29 sa=0 sb=0 sd=0
+ mult=1
XMN4 d4 d3 VGND VGND sky130_fd_pr__nfet_01v8 L=2.3 W=0.42 nf=1 ad=0.1218 as=0.1218 pd=1.42 ps=1.42 nrd=0.69047619047619
+ nrs=0.69047619047619 sa=0 sb=0 sd=0 mult=1
XMP5 y d4 VDPWR VDPWR sky130_fd_pr__pfet_01v8 L=2.3 W=1 nf=1 ad=0.29 as=0.29 pd=2.58 ps=2.58 nrd=0.29 nrs=0.29 sa=0 sb=0 sd=0
+ mult=1
XMN5 y d4 VGND VGND sky130_fd_pr__nfet_01v8 L=2.3 W=0.42 nf=1 ad=0.1218 as=0.1218 pd=1.42 ps=1.42 nrd=0.69047619047619
+ nrs=0.69047619047619 sa=0 sb=0 sd=0 mult=1
.ends

.end
