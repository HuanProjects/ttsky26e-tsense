* bgr_chop: layout-only cell for a standalone LVS. The four device lines are copied unchanged from the frozen bgr top
* level in ../xschem/simulation/bgr.spice (sha256 dc656f11...); only the subckt wrapper is added.
.subckt bgr_chop va vb inn inp swa swb VGND
XS1 va swa inn VGND sky130_fd_pr__nfet_01v8_lvt L=0.5 W=4 nf=1 ad=1.16 as=1.16 pd=8.58 ps=8.58 nrd=0.0725 nrs=0.0725 sa=0 sb=0
+ sd=0 mult=1
XS2 vb swa inp VGND sky130_fd_pr__nfet_01v8_lvt L=0.5 W=4 nf=1 ad=1.16 as=1.16 pd=8.58 ps=8.58 nrd=0.0725 nrs=0.0725 sa=0 sb=0
+ sd=0 mult=1
XS3 va swb inp VGND sky130_fd_pr__nfet_01v8_lvt L=0.5 W=4 nf=1 ad=1.16 as=1.16 pd=8.58 ps=8.58 nrd=0.0725 nrs=0.0725 sa=0 sb=0
+ sd=0 mult=1
XS4 vb swb inn VGND sky130_fd_pr__nfet_01v8_lvt L=0.5 W=4 nf=1 ad=1.16 as=1.16 pd=8.58 ps=8.58 nrd=0.0725 nrs=0.0725 sa=0 sb=0
+ sd=0 mult=1
.ends
