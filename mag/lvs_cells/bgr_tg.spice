* bgr_tg: layout-only cell for a standalone LVS: one transmission gate + dump switch of the frozen bgr top level
* (XS_ichon_n / XS_ichon_p / XS_ichdump, and the same three for i3), with generic pin names:
* a = ich or vref, b = ichb or i3b, on / onb / dump = the gate controls. Device parameters copied unchanged.
.subckt bgr_tg a b on onb dump VDPWR VGND
XN b on a VGND sky130_fd_pr__nfet_01v8 L=0.5 W=2 nf=1 ad=0.58 as=0.58 pd=4.58 ps=4.58 nrd=0.145 nrs=0.145 sa=0 sb=0 sd=0
+ mult=1
XP b onb a VDPWR sky130_fd_pr__pfet_01v8 L=0.5 W=4 nf=1 ad=1.16 as=1.16 pd=8.58 ps=8.58 nrd=0.0725 nrs=0.0725 sa=0 sb=0
+ sd=0 mult=1
XD b dump VGND VGND sky130_fd_pr__nfet_01v8 L=0.5 W=1 nf=1 ad=0.29 as=0.29 pd=2.58 ps=2.58 nrd=0.29 nrs=0.29 sa=0 sb=0
+ sd=0 mult=1
.ends
